# Ansys Electronics Desktop project, version 2020.1
materials:
  vacuum: permittivity=1
  copper135C: permeability=0.999991 conductivity=40715418

design HFSSDesign1 (HFSS, DrivenModal, model units mm)
options: Calculate_Lossy_Dielectrics
variables:
  width_WG = 0.072136
  height_WG = 0.034036
geometry:
  Polyline1 [vacuum] = polyline(z=0, xy: (0, (0.034036) / 2) ((0.072136) / 2, (0.034036) / 2) ((0.072136) / 2, (-(0.034036)) / 2) (0, (-(0.034036)) / 2) ((-(0.072136)) / 2, (-(0.034036)) / 2) ((-(0.072136)) / 2, (0.034036) / 2) (0, (0.034036) / 2), closed, covered)
  Polyline1.sweep_along_vector((0, 0, 0.072136))
boundaries and excitations:
  FiniteCond1: Finite Conductivity Faces=Polyline1.face(#22, #23, #24, #25) UseMaterial Material=copper135C
  1: Wave Port Faces=Polyline1.face(at (0, 0, 0)) NumModes=1 Modes{Mode1{CharImp=Zpi}}
  2: Wave Port Faces=Polyline1.face(#26) NumModes=1 Modes{Mode1{CharImp=Zpi}}
setups:
  Setup1: HfssDriven Frequency=3950000000Hz MaxDeltaS=0.02 MaximumPasses=20 MinimumPasses=2 MinimumConvergedPasses=2 PercentRefinement=30 BasisOrder=2 Target=0.6667 PortAccuracy=2
source amplitudes:
  1:1: 1W 0deg
  2:1: 0W 0deg
